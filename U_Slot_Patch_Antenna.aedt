# Ansys Electronics Desktop project, version 2022.1
materials:
  vacuum: permittivity=1
  copper: permeability=0.999991 conductivity=58000000
  Teflon (tm): permittivity=2.1 dielectric_loss_tangent=0.001
  pec: conductivity=1e+30
  Rogers RO4003 (tm): permittivity=3.55 dielectric_loss_tangent=0.0027

design USlotPatch (HFSS, DrivenModal, model units mm)
options: Allow_Material_Override
variables:
  SlotW = 2.6509mm
  SlotL = 3.7059mm
  SlotY = 1.3342mm
  SlotThickness = 0.99237mm
  PatchW = 10.357mm
  PatchL = 6.8108mm
  FeedY = -1.1885mm
  SubW = 25mm
  SubL = 25mm
  SubH = 1.524mm+0.813mm
  CuThickness = 50um
  FeedX = 0mm
  FeedL = 1mm
  FeedDielRad = 0.5mm
  FeedCenterRad = 0.15mm
geometry:
  Substrate [Rogers RO4003 (tm)] = box(corner=(-SubW/2, -SubL/2, -SubH/2), size=(SubW, SubL, SubH))
  Ground [copper] = object_from(Substrate.face(-z))
  Ground.thicken(CuThickness)
  Patch [copper] = box(corner=(-PatchW/2, -PatchL/2, SubH/2), size=(PatchW, PatchL, CuThickness))
  FeedDiel [Teflon (tm)] = cylinder(axis=Z, base_centre=(FeedX, FeedY, -SubH/2), radius=FeedDielRad, height=-FeedL)
  FeedWall [copper] = object_from(FeedDiel.face(1 of 3))
  FeedWall.thicken(CuThickness)
  FeedCenter [copper] = cylinder(axis=Z, base_centre=(FeedX, FeedY, SubH/2+CuThickness), radius=FeedCenterRad, height=-FeedL-SubH-CuThickness)
  FeedDiel_1 = FeedDiel.copy()
  Ground.subtract(FeedDiel_1)
  PortCap [pec] = object_from(FeedDiel.face(2 of 3))
  PortCap.thicken(CuThickness)
  PortCap.move_faces(MoveAlongNormalFlag=true OffsetDistance=CuThickness FacesToMove=PortCap.face(#164))
  USlot = box(corner=(-SlotW/2, SlotY, SubH/2), size=(SlotW, SlotThickness, CuThickness))
  USlot_ObjectFromFace1, USlot_ObjectFromFace2 = object_from(USlot_ObjectFromFace1.face(4 of 6, 6 of 6))
  [USlot_ObjectFromFace1, USlot_ObjectFromFace2].thicken(SlotThickness)
  USlot_ObjectFromFace1.move_faces(MoveAlongNormalFlag=true OffsetDistance=SlotL FacesToMove=USlot_ObjectFromFace1.face(#305))
  USlot_ObjectFromFace2.move_faces(MoveAlongNormalFlag=true OffsetDistance=SlotL FacesToMove=USlot_ObjectFromFace1.face(#330))
  USlot_ObjectFromFace1.unite(USlot, USlot_ObjectFromFace2)
  Patch.subtract(USlot_ObjectFromFace1)
  RadiatingSurface [vacuum] = region(absolute_offset=10mm on all sides)
boundaries and excitations:
  Open1: Radiation Objects=RadiatingSurface
  1: Wave Port Faces=PortCap.face(#163) NumModes=1 Modes{Mode1{CharImp=Zpi}}
setups:
  Setup1: HfssDriven Frequency=10GHz MaxDeltaS=0.02 MaximumPasses=20 MinimumPasses=1 MinimumConvergedPasses=2 PercentRefinement=30 BasisOrder=1 PortAccuracy=2 DrivenSolverType="Direct Solver"
    sweep Sweep: 8GHz to 12GHz, 401 points; Type=Interpolating InterpTolerance=0.5 InterpMaxSolns=250 InterpUsePortImped=false PassivityErrorTolerance=0.0001
source amplitudes:
  1:1: 1W 0deg
radiation setups:
  3D: Infinite Sphere Theta=0deg..180deg step 2deg Phi=-180deg..180deg step 2deg
  Elevation: Infinite Sphere Theta=-180deg..180deg step 1deg Phi=0deg..90deg step 90deg
  Azimuth: Infinite Sphere Theta=90deg..90deg step 0deg Phi=-180deg..180deg step 1deg
  MySphere: Infinite Sphere Theta=-180deg..180deg step 1deg Phi=0deg..90deg step 90deg
reports:
  SParams: dB(S(1,1)) vs Freq on Setup1 : Sweep; markers MY1 at y=-10.0242
  Realized Gain Plot 3: dB(RealizedGainTotal) vs Phi, Theta on Setup1 : LastAdaptive, 3D [Freq=10GHz]
  Realized Gain Plot 4: dB(PeakRealizedGain) vs Freq

design USlotPatch1 (HFSS, Characteristic Mode, model units mm)
options: Allow_Material_Override
variables:
  SlotW = 2.6509mm
  SlotL = 3.7059mm
  SlotY = 1.3342mm
  SlotThickness = 0.99237mm
  PatchW = 10.357mm
  PatchL = 6.8108mm
  FeedY = -1.1885mm
  SubW = 25mm
  SubL = 25mm
  SubH = 1.524mm+0.813mm
  CuThickness = 50um
  FeedX = 0mm
  FeedL = 1mm
  FeedDielRad = 0.5mm
  FeedCenterRad = 0.15mm
geometry:
  Substrate = box(corner=(-SubW/2, -SubL/2, -SubH/2), size=(SubW, SubL, SubH))
  Ground [copper] = object_from(Substrate.face(-z))
  Substrate.delete()
  Ground.thicken(CuThickness)
setups:
  Setup1: HfssCMA ModalSignificance=0.02 MaxDeltaE=0.02 AdaptiveFreq=10GHz MaximumPasses=3 MinimumPasses=1 MinimumConvergedPasses=1 PercentRefinement=30 BasisOrder=0
    sweep Sweep: 7GHz to 11GHz, 9 points; Type=Discrete
source amplitudes:
  #-10:1, #-10:2, #-10:4..#-10:10: 0W 0deg
  #-10:3: 1W 0deg
radiation setups:
  3D: Infinite Sphere Theta=0deg..180deg step 2deg Phi=-180deg..180deg step 2deg
  Elevation: Infinite Sphere Theta=-180deg..180deg step 1deg Phi=0deg..90deg step 90deg
  Azimuth: Infinite Sphere Theta=90deg..90deg step 0deg Phi=-180deg..180deg step 1deg
  MySphere: Infinite Sphere Theta=-180deg..180deg step 1deg Phi=0deg..90deg step 90deg
reports:
  Characteristic Mode Plot 1: Significance(1), Significance(2), Significance(3), Significance(4), Significance(5), Significance(6), Significance(7), Significance(8), Significance(9), Significance(10) vs Freq on Setup1 : Sweep

design USlotPatch2 (HFSS, Characteristic Mode, model units mm)
options: Allow_Material_Override
variables:
  SlotW = 2.6509mm
  SlotL = 3.7059mm
  SlotY = 1.3342mm
  SlotThickness = 0.99237mm
  PatchW = 10.357mm
  PatchL = 6.8108mm
  FeedY = -1.1885mm
  SubW = 25mm
  SubL = 25mm
  SubH = 1.524mm+0.813mm
  CuThickness = 50um
  FeedX = 0mm
  FeedL = 1mm
  FeedDielRad = 0.5mm
  FeedCenterRad = 0.15mm
geometry:
  Substrate = box(corner=(-SubW/2, -SubL/2, -SubH/2), size=(SubW, SubL, SubH))
  Ground [copper] = object_from(Substrate.face(-z))
  Substrate.delete()
  Ground.thicken(CuThickness)
setups:
  Setup1: HfssCMA ModalSignificance=0.5 MaxDeltaE=0.02 AdaptiveFreq=10GHz MaximumPasses=3 MinimumPasses=1 MinimumConvergedPasses=1 PercentRefinement=30 BasisOrder=0
    sweep Sweep: 7GHz to 11GHz, 9 points; Type=Discrete
source amplitudes:
  #-10:1, #-10:2, #-10:4..#-10:10: 0W 0deg
  #-10:3: 1W 0deg
radiation setups:
  3D: Infinite Sphere Theta=0deg..180deg step 2deg Phi=-180deg..180deg step 2deg
  Elevation: Infinite Sphere Theta=-180deg..180deg step 1deg Phi=0deg..90deg step 90deg
  Azimuth: Infinite Sphere Theta=90deg..90deg step 0deg Phi=-180deg..180deg step 1deg
  MySphere: Infinite Sphere Theta=-180deg..180deg step 1deg Phi=0deg..90deg step 90deg
reports:
  Characteristic Mode Plot 1: Significance(1), Significance(2), Significance(3), Significance(4), Significance(5), Significance(6), Significance(7), Significance(8), Significance(9), Significance(10) vs Freq on Setup1 : Sweep
